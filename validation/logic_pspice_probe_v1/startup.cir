Logic supply candidate nominal startup - NOT whole-board qualification
.LIB "TPS26601_TRANS.LIB"
.LIB "TPS70933_TRANS.LIB"
Vsource BATTERY_RAW 0 PWL(0 0 100u 12.6 10m 12.6)
Xprotect PROTECT_OPEN_22 LOGIC_PROTECT_RTN PROTECT_OPEN_14 PROTECT_OPEN_13 LOGIC_ILIM PROTECT_OPEN_1 PROTECT_OPEN_2 PROTECT_OPEN_20 PROTECT_OPEN_18 LOGIC_UVLO LOGIC_OVP LOGIC_PROTECT_RTN LOGIC_PROTECTED_INPUT LOGIC_PROTECTED_INPUT BATTERY_RAW BATTERY_RAW 0 TPS26601_TRANS
Xldo LOGIC_PROTECTED_INPUT 0 LDO_OPEN_4 LOGIC3V3 LDO_OPEN_2 TPS70933_TRANS
R_LOGIC_UV_TOP BATTERY_RAW LOGIC_UVLO 40200
R_LOGIC_UV_BOTTOM LOGIC_UVLO LOGIC_PROTECT_RTN 10000
R_LOGIC_OV_TOP BATTERY_RAW LOGIC_OVP 124000
R_LOGIC_OV_BOTTOM LOGIC_OVP LOGIC_PROTECT_RTN 10000
R_LOGIC_ILIM LOGIC_ILIM LOGIC_PROTECT_RTN 118000
R_LOGIC_INPUT_BLEED BATTERY_RAW 0 100000
C_LOGIC_PROTECT_IN_1 BATTERY_RAW 0 1e-07
C_LOGIC_PROTECT_IN_2 BATTERY_RAW 0 1e-07
C_LOGIC_PROTECT_OUT_1 LOGIC_PROTECTED_INPUT 0 1e-07
C_LOGIC_PROTECT_OUT_2 LOGIC_PROTECTED_INPUT 0 1e-07
Cprobe LOGIC3V3 0 27.975u
Rprobe LOGIC3V3 0 165
.TRAN 1u 10m 0 1u
.PROBE V(BATTERY_RAW) V(LOGIC_PROTECTED_INPUT) V(LOGIC3V3) I(Vsource)
.END
