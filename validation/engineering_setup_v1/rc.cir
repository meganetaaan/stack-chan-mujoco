RC transient benchmark; 1 kohm, 1 uF, 5 V step
Vstep in 0 PULSE(0 5 0 1n 1n 10m 20m)
R1 in out 1k
C1 out 0 1u IC=0
.control
set wr_singlescale
set wr_vecnames
tran 1u 3m uic
wrdata rc.dat v(out)
quit
.endc
.end
