Pack controller nominal compatibility/startup probe; NOT full load qualification
.LIB "TPS26600_TRANS.LIB"
.LIB "TPS70933_TRANS.LIB"
Vsource PACK_FUSED_REVERSE_PROTECTED 0 PWL(0 0 100u 12.6 50m 12.6)
XU_CTRL_INPUT_LIMIT U_CTRL_INPUT_LIMIT_OPEN_22 CTRL_INPUT_PROTECT_RTN U_CTRL_INPUT_LIMIT_OPEN_14 CTRL_INPUT_MODE CTRL_INPUT_ILIM U_CTRL_INPUT_LIMIT_OPEN_1 U_CTRL_INPUT_LIMIT_OPEN_2 CTRL_INPUT_DVDT U_CTRL_INPUT_LIMIT_OPEN_18 CTRL_INPUT_UVLO CTRL_INPUT_OVP CTRL_INPUT_PROTECT_RTN CONTROL_INPUT_PROTECTED CONTROL_INPUT_PROTECTED PACK_FUSED_REVERSE_PROTECTED PACK_FUSED_REVERSE_PROTECTED 0 TPS26600_TRANS
XCTRL__U_LDO CONTROL_INPUT_PROTECTED 0 CTRL__U_LDO_OPEN_3 CTRL3V3 CTRL__U_LDO_OPEN_4 TPS70933_TRANS
CCTRL__C_HOST_HF CTRL3V3 0 1e-07
CCTRL__C_HOST_BULK CTRL3V3 0 4.7e-06
CCTRL__C_HOST_SUP CTRL3V3 0 1e-07
CCTRL__C_WD CTRL3V3 0 1e-07
CCTRL__C_RESET_BUFFER CTRL3V3 0 1e-07
CCTRL__C_PERMIT_LATCH CTRL3V3 0 1e-07
CCTRL__C_MAIN_GATE CTRL3V3 0 1e-07
CCTRL__C_AUX_GATE CTRL3V3 0 1e-07
CCTRL__C_LDO_IN CONTROL_INPUT_PROTECTED 0 2.2e-06
CCTRL__C_LDO_OUT CTRL3V3 0 4.7e-06
RR_CTRL_INPUT_UV_TOP PACK_FUSED_REVERSE_PROTECTED CTRL_INPUT_UVLO 40200
RR_CTRL_INPUT_UV_BOTTOM CTRL_INPUT_UVLO CTRL_INPUT_PROTECT_RTN 10000
RR_CTRL_INPUT_OV_TOP PACK_FUSED_REVERSE_PROTECTED CTRL_INPUT_OVP 124000
RR_CTRL_INPUT_OV_BOTTOM CTRL_INPUT_OVP CTRL_INPUT_PROTECT_RTN 10000
RR_CTRL_INPUT_ILIM CTRL_INPUT_ILIM CTRL_INPUT_PROTECT_RTN 118000
CC_CTRL_INPUT_PROTECT_IN_1 PACK_FUSED_REVERSE_PROTECTED 0 1e-07
CC_CTRL_INPUT_PROTECT_IN_2 PACK_FUSED_REVERSE_PROTECTED 0 1e-07
CC_CTRL_INPUT_PROTECT_OUT_1 CONTROL_INPUT_PROTECTED 0 1e-07
CC_CTRL_INPUT_PROTECT_OUT_2 CONTROL_INPUT_PROTECTED 0 1e-07
RR_CTRL_INPUT_MODE CTRL_INPUT_MODE CTRL_INPUT_PROTECT_RTN 402000
CC_CTRL_INPUT_DVDT CTRL_INPUT_DVDT CTRL_INPUT_PROTECT_RTN 1e-07
CIF_CLEAR__C_HF CTRL3V3 0 1e-07
CIF_CLEAR__C_SCHMITT CTRL3V3 0 1e-07
Rload CTRL3V3 0 272.067211622
.TRAN 1u 50m 0 1u
.PROBE V(PACK_FUSED_REVERSE_PROTECTED) V(CONTROL_INPUT_PROTECTED) V(CTRL3V3) I(Vsource)
.END
